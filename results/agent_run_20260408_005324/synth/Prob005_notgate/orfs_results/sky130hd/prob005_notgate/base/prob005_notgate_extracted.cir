* Extracted by KLayout on : 07/04/2026 17:03

.SUBCKT prob005_notgate VDD VSS VNB
X$3 VDD \$20 VSS VDD \$1 VNB sky130_fd_sc_hd__clkdlybuf4s50_1
X$6 VDD \$1 VDD VSS \$21 VNB sky130_fd_sc_hd__inv_1
X$260 VDD \$21 VSS VDD \$22 VNB sky130_fd_sc_hd__clkdlybuf4s50_1
.ENDS prob005_notgate

.SUBCKT sky130_fd_sc_hd__inv_1 VPB A VPWR VGND Y VNB
M$1 Y A VPWR VPB pfet_01v8_hvt L=150000U W=1000000U AS=260000000000P
+ AD=260000000000P PS=2520000U PD=2520000U
M$2 Y A VGND VNB nfet_01v8 L=150000U W=650000U AS=169000000000P
+ AD=169000000000P PS=1820000U PD=1820000U
.ENDS sky130_fd_sc_hd__inv_1

.SUBCKT sky130_fd_sc_hd__clkdlybuf4s50_1 VPB A VGND VPWR X VNB
M$1 \$7 \$6 VPWR VPB pfet_01v8_hvt L=500000U W=820000U AS=155750000000P
+ AD=217300000000P PS=1325000U PD=2170000U
M$2 X \$7 VPWR VPB pfet_01v8_hvt L=150000U W=1000000U AS=155750000000P
+ AD=355000000000P PS=1325000U PD=2710000U
M$3 VPWR A \$4 VPB pfet_01v8_hvt L=150000U W=1000000U AS=270000000000P
+ AD=170100000000P PS=2540000U PD=1360000U
M$4 \$6 \$4 VPWR VPB pfet_01v8_hvt L=500000U W=820000U AS=170100000000P
+ AD=217300000000P PS=1360000U PD=2170000U
M$5 X \$7 VGND VNB nfet_01v8 L=150000U W=420000U AS=97000000000P
+ AD=149100000000P PS=975000U PD=1550000U
M$6 VGND \$6 \$7 VNB nfet_01v8 L=500000U W=650000U AS=172250000000P
+ AD=97000000000P PS=1830000U PD=975000U
M$7 VGND A \$4 VNB nfet_01v8 L=150000U W=420000U AS=113400000000P
+ AD=104350000000P PS=1380000U PD=1010000U
M$8 \$6 \$4 VGND VNB nfet_01v8 L=500000U W=650000U AS=104350000000P
+ AD=169000000000P PS=1010000U PD=1820000U
.ENDS sky130_fd_sc_hd__clkdlybuf4s50_1
